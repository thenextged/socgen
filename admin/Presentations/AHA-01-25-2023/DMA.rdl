//------------------------------------------------------------------------------
// SystemRDL v2.0
//------------------------------------------------------------------------------
// Purpose  : AHA DMA Register Space Description
// -----------------------------------------------------------------------------
// Author   : Gedeon Nyengele
// Date     : March 9, 2022
//------------------------------------------------------------------------------

addrmap aha_dma {

    name    = "aha_dma";
    desc    = "Register space definition for AHA DMA";

    default addressing      = regalign;
    default regwidth        = 32;
    default accesswidth     = 32;
    default alignment       = 4;

    default littleendian;
    default lsb0;

    default sw              = rw;
    default hw              = r;

    //
    // Control Register
    //

    reg {
        name    = "CTRL";
        desc    = "Control Register";

        // Field : GO
        field {
            desc    = "Start DMA Transfer";
        } GO[0:0] = 0x0;

        // Field : IE
        field {
            desc    = "Interrupt Enable";
        } IE[1:1] = 0x0;
    } CTRL @ 0x00;

    //
    // Status Register
    //

    reg {
        name    = "STAT";
        desc    = "Status Register";

        // Field : BUSY
        field {
            desc    = "State of DMA Engine";
            sw      = r;
        } BUSY [0:0] = 0x0;

        // Field : INTR
        field {
            desc    = "Interrupt Status";
            sw      = r;
        } INTR[1:1] = 0x0;

        // Field : STAT_CODE
        field {
            desc    = "xRESP Value for Transfer";
            sw      = r;
        } STAT_CODE[3:2] = 0x0;
    } STAT @ 0x04;

    //
    // Interrupt Clear Register
    //

    reg {
        name    = "INTR_CLR";
        desc    = "Interrupt Clear Register";

        // Field : CLR
        field {
            desc    = "Interrupt Clear";
            woclr;
        } CLR[1:1] = 0x0;
    } INTR_CLR @ 0x08;

    //
    // Source Address Register
    //

    reg {
        name    = "SA";
        desc    = "Source Address Register";

        // Field : ADDR
        field {
            desc    = "8-Byte Aligned Address";
        } ADDR[31:3] = 0x0;

    } SA @ 0x0C;

    //
    // Destination Address Register
    //

    reg {
        name    = "DA";
        desc    = "Destination Address Register";

        // Field : ADDR
        field {
            desc    = "8-Byte Aligned Address";
        } ADDR[31:3] = 0x0;
    } DA @ 0x10;

    //
    // Transfer Size Register
    //

    reg {
        name    = "LEN";
        desc    = "Transfer Size/Length in Bytes";

        // Field : SIZE
        field {
            desc    =   "Transfer Size in Bytes";
        } SIZE[31:0] = 0x0;
    } LEN @ 0x14;

    //
    // ID Register
    //

    reg {
        name    = "ID";
        desc    = "Engine ID";

        // Field : ID
        field {
            desc    = "Engine ID";
            sw      = r;
        } ID[31:0] = 0x5A5A5A5A;
    } ID @ 0x1C;
};
